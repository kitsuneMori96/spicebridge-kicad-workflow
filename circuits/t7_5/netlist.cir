* 题 7-5：开关 S 原在位置 1 已久，t=0 合向位置 2。求 u_C(t) 和 i(t)
* 5V—25kΩ—(触点1)；动触点接节点 c；(触点2)—100kΩ—地，i 就是这只 100kΩ 的下向电流
* 节点 c = 电容上板 = 左侧 100kΩ 上端 = 开关动触点
* Rsw1/Rsw2 是开关的两条腿：位置 1 = Rsw1 闭合 + Rsw2 打开，位置 2 反之。
* 本文件给的是换路前（位置 1）的状态。
* Vram 是 0V 理想电流表，i(vram) = i（n2→100kΩ→地 为正）。名字首字母决定元件类型，
* 写成 Ram 会被静默解析成电阻，i(ram) 取不到。
* 容性电路可以**先断后合**（与 7-3(b) 的感性回路相反）：断开的瞬间电容只是暂时孤立，
* 电压不会跳变，不存在 L·di/dt 撞 roff 的 1e12 V 尖峰。
V5 s 0 5
R25k s n1 25k
Rsw1 n1 c 1e-6
Rsw2 c n2 1e9
R100a c 0 100k
C1 c 0 10u
Vram n2 pm 0
R100b pm 0 100k
.end
