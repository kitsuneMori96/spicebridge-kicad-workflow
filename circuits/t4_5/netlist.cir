* 教材 T4.5：A_u(jf) = -10jf / [(1+jf/10)(1+jf/10^5)]
* 中频增益 |A_um| = 1000 (60 dB)，fL = 10 Hz，fH = 10^5 Hz
* 实现：CR 高通(10 Hz) × 增益 100 × RC 低通(100 kHz)，缓冲隔离
Vin in 0 AC 1
* --- 高通：fL = 1/(2*pi*R1*C1) = 10 Hz
C1 in b1 1u
R1 b1 0 15915.4943
E2 b1b 0 b1 0 1
* --- 中频增益 100
E3 b2 0 b1b 0 100
* --- 低通：fH = 1/(2*pi*R2*C2) = 100 kHz
R2 b2 out 1k
C2 out 0 1.59154943n
R3 out 0 1meg
.end
