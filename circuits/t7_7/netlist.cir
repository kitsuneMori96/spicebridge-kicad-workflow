* 题 7-7：S 断开已久（零状态），t=0 合上。求电流 i（中间 150Ω 支路，向下）
* 三条支路都接在节点 m 与地之间：左 100Ω+0.1H、中 150Ω+60V（经开关 S）、右 20µF+100Ω
* Rsw 就是开关 S：断开填 1e9、闭合填 1e-6，本文件给换路前（断开）
* Vam 是 0V 理想电流表，i(vam) = i（d→60V 源 为正）。首字母决定元件类型，别写 Ram
R100a p 0 100
L1 p m 0.1
C1 m r 20u
R100b r 0 100
Rsw m d 1e9
Vam d dm 0
R150 dm src 150
V60 src 0 60
.end
