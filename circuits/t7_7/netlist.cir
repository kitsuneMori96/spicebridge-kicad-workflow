* 题 7-7：S 断开已久、电路已达稳态；t=0 时 S 闭合。求 t≥0 的电流 i（m→k，向下）
* 拓扑（按放大后的原图核对）：m 是 0.1H 与 20µF 之间的节点，m 向下一条线到 k，线上标着 i；
*   k 到地有两条**并联**支路：一条是开关 S，另一条是 150Ω+60V（60V 的 + 极朝上、接 150Ω）。
*   外围：100Ω(p—地)—0.1H(p—m)—20µF(m—r)—100Ω(r—地) 构成一个串联回路。
* 关键：S 断开时中支路**不悬空**——150Ω+60V 仍接在 m 与地之间，所以换路前不是零状态：
*   v(m) = 60·100/(100+150) = 24 V，i_L = −0.24 A，u_C = 24 V（数值由仿真解出，不是手填）
* Rsw 就是开关 S：断开填 1e9、闭合填 1e-6；本文件给的是换路前的状态（断开）
* VamL、Vam 是 0V 理想电流表：i(vaml) = i_L（p→pl→m），i(vam) = i（m→k）。
*   元件名首字母决定类型，写成 Ram 会被解析成电阻（静默不报错，i(ram) 取不到）
R100a p 0 100
VamL p pl 0
L1 pl m 0.1
C1 m r 20u
R100b r 0 100
Vam m k 0
R150 k g 150
V60 g 0 60
Rsw k 0 1e9
.end
