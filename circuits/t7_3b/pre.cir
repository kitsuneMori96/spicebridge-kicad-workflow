* 题 7-3(b) 换路前：S 在位置 1，已达稳态（电感短路）
* 3A∥20Ω 在 n1；n1—30Ω—(n2)—10H—地
I3 0 n1 3
R20 n1 0 20
R30 n1 n2 30
L1 n2 0 10
.end
