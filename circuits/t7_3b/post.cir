* 题 7-3(b) 换路后：S 打到位置 2
* 左侧 3A∥20Ω 被断开，自成回路；右侧回路 = 15Ω — 30Ω — 10H
* Vsw 是位置 2 的闭合开关：0V 源既短接两节点，又能读出回路电流
* 这里不写 `ic=`：solve.py 每步都按 1) 实测的 i_L(0−) 整行重建 L1，写死初值只会误导
I3 0 n1 3
R20 n1 0 20
Vsw piv k 0
R15 k 0 15
R30 piv n2 30
L1 n2 0 10
.end
