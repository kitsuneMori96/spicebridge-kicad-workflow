* 教材 4.6：放大器频率响应  A_u(jf) = 200jf / ((1+j f/10)(1+j f/1e4)(1+j f/1e5))
* 等效实现：CR 高通（f1=10 Hz）× 增益 2000 × 两级 RC 低通（f2=10 kHz, f3=100 kHz）
* 各段之间用理想缓冲隔离，保证总传递函数严格等于题给表达式
Vin in 0 AC 1
* --- 下限频率：耦合电容 C1 + R1，f1 = 1/(2*pi*R1*C1) = 10 Hz
C1 in b1 1u
R1 b1 0 15915.494309
E2 b1b 0 b1 0 1
* --- 中频增益 2000（66 dB）
E3 b2 0 b1b 0 2000
* --- 上限频率第一极点：f2 = 1/(2*pi*R2*C2) = 10 kHz
R2 b2 b3 1k
C2 b3 0 15.9154943n
E4 b3b 0 b3 0 1
* --- 上限频率第二极点：f3 = 1/(2*pi*R3*C3) = 100 kHz
R3 b3b out 1k
C3 out 0 1.59154943n
R4 out 0 1meg
