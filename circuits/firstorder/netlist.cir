* 邱关源 一阶电路零状态响应 → 三要素回归用例（同戴维南网络，端口接 0.8F 电容）
* 开关 S 在 t=0 闭合 = 激励源 t=0 阶跃，t<0 全网络为零 → 天然零状态
* 解析：u_C(∞)=1.5 V, Req=1.25Ω → τ=Req·C=1.25×0.8=1 s, i1(0+)=0.8 A
V1 n2 0 PULSE(0 2 0 1e-6 1e-6 1e4 2e4)
R1 n2 a 1
R2 a m 1
E1 m 0 n2 a 2
R3 a c 1
C1 c 0 0.8
.end
