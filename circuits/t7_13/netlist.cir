* 题 7-13：u_C(0−)=0，t=0 时 S 闭合，求 t≥0 的 u_C(t)、i_C(t)
* 拓扑（按拍图逐段核对，并用幻灯片印出的答案反推校核）：
*   上节点 a = 2Ω 上端 = 右 2Ω 上端 = 开关的一条腿；下节点 0 是公共地。
*   中支路（自下而上）：0 —Vctrl(0V 电流表)— c —20V 源(+ 在 n2 侧)— n2 —2Ω— a。
*     图上 i 的参考方向是**向上**（i 箭头指向上节点），i = i(vctrl)。
*   左支路是**电流控制电流源(CCCS)**，Fcccs 从 0 流向 a（向上）8i。
*     注意：若把它看成 CCVS(菱形里带 +/−)，Req 会变成 2Ω∥2Ω=1Ω、τ=0.1s、
*     u_C(∞)=16V，和幻灯片给的 18V / e^(−50t) 全对不上——截图里菱形中那根
*     横线是电流源的箭头，不是电位极性。
*   右支路 R3 = 2Ω，常接在 a—0 之间。
*   S 在 a 与电容上板 cp 之间；电容 C=0.1F，u_C 的 + 在 cp 侧，i_C = C·du_C/dt。
*   Vic 是与 C 串联的 0V 电流表，i(vic) 即 i_C（cp→cp2 向下为正）。
* Rsw1/Rsw2 是 S 的两个掷：换路前 Rsw1 合（cp 接地，u_C 恰好为 0）、Rsw2 断；
*   换路后反过来。真实电路里 S 断开时电容上板悬空、电荷为零——SPICE 不允许悬空
*   节点，靠 roff 拉到 a 反而会"充"出 v(a) 的假初值；把断开那一掷接到地，等价于
*   把这块零电荷的孤立极板钉在 0V，且理想电容不取直流电流，源网络不受影响。
*   本文件给的是换路前（位置 1）的状态。
Vctrl 0 c 0
V20 n2 c 20
R2 n2 a 2
Fcccs 0 a Vctrl 8
R3 a 0 2
Vic cp cp2 0
C1 cp2 0 0.1
Rsw1 cp 0 1e-6
Rsw2 cp a 1e9
.end
