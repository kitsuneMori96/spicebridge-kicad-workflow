* 题 7-4：开关未动作前已达稳态，t=0 时 S 打开。求 u_C(0+)、i_L(0+)、du_C/dt、di_L/dt、di_R/dt
* 12V—[6Ω ∥ (6Ω+S)]—(a)；a—0.1H—(b)—3Ω—地；a—(1/24)F—地
* i_R 是中间那只 6Ω 的电流（图里箭头向右），i_C 参考方向向下、流入 u_C 的 + 板
* Rsw 就是开关 S：闭合填 1e-6、打开填 1e9，本文件给的是换路前的状态（闭合）。
* Vram 是 0V 理想电流表：ngspice 读不到电阻支路电流，只能串表，i(vram) = i_R（s→a 取正）
* 名字首字母决定元件类型，写成 Ram 会被解析成电阻（静默不报错，i(vram) 取不到）
* 二阶电路（L、C 各占一个节点，合不成一只等效储能元件），所以没有 τ，响应是衰减振荡
V12 s 0 12
Vram s rm 0
R6m rm a 6
R6t s w1 6
Rsw w1 a 1e-6
L1 a b 0.1
C1 a 0 41.6666666667m
R3 b 0 3
.end
