* 邱关源 含受控源一端口 → 戴维南回归用例
* 端口 = c/0（电容接 here，但等效电阻测试网络里没有储能元件）
*   2V —R1 1Ω—(a)—R2 1Ω—(m)— E1: V(m)=2·i1 —0      i1 = R1 支路电流
*                    └——R3 1Ω——(c)—[端口]—0
* 解析：Voc = 1.5 V, Isc = 1.2 A, Req = Voc/Isc = 1.25 Ω（受控源把 2Ω 拉低）
V1 n2 0 2
R1 n2 a 1
R2 a m 1
E1 m 0 n2 a 2
R3 a c 1
RP c 0 1e12
.end
