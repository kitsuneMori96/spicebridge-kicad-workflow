* 实验5.15 一阶 RC 零状态响应回归用例：R=10kΩ, C=6800pF → τ=68µs
* 单阶跃 0→3 V，t<0 全网络为零，天然零状态；t≫5τ 后 u_C→3 V
V1 in 0 PULSE(0 3 0 1e-9 1e-9 1 2)
R1 in out 10k
C1 out 0 6800p
.end
