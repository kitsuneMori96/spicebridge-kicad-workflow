* 串联 RLC 谐振 + 相量回归用例
* L=10mH C=1uF → ω0=1/√LC=10⁴ rad/s, f0=1591.55 Hz;  Q=ω0L/R=100/20=5
* 输出取 R1 顶端 n2：V(n2)=I·R 与支路电流同形状，峰值**恰好**在 ω0（取电容电压会偏 1%）
* RP 是"接线柱"电阻：phasor() 把它整只换成 0V 理想电流表，故其阻值只影响 resonance()
Vac in 0 AC 1
RP in a 1e-3
L1 a n1 10m
C1 n1 n2 1u
R1 n2 0 20
.end
