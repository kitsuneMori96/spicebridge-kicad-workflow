* 题 7-3(a)：S 在 t=0 闭合，求 0+ 时刻电压电流
* 30V—15Ω—[S]—(a)；a—5Ω—10V源—地；a—1μF—(p)—25Ω—地
* Rsw 就是开关：断开填 1e9、闭合填 1e-6，换路前后各解一次直流（替代定理那条路用得到）。
* 瞬态那一步不用它——solve.py 把这一行换成真 `sw` 压控开关 + 方波控制极（circ.switch_lines），
* 让 ngspice 自己算出换路前的状态，两种开关写法互相对账。
* Vsen 是 0V 理想电流表，i(vsen) = 电容支路电流
V1 s 0 30
R15 s w1 15
Rsw w1 a 1e9
R5 a d1 5
V10 d1 0 10
C1 a p 1u
Vsen p p2 0
R25 p2 0 25
.end
