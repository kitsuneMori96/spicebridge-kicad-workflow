* 题 7-6：S 在位置 1 已久，t=0 合向位置 2。求换路后的 i(t) 与 u_L(t)
* 10V—1Ω—(位置1)；动触点接节点 c；c—1H—(b)—4Ω—地；位置2—4Ω—地
* i 是电感电流（c→b），u_L 的 + 在 c 侧
* S 是 SPDT：位置 1 = Rsw1 闭合 + Rsw2 打开，位置 2 反之；本文件给换路前（位置 1）
* 换路后回路只剩 1H 串两只 4Ω（8Ω）→ τ = L/R = 0.125 s
V10 s 0 10
R1 s n1 1
Rsw1 n1 c 1e-6
Rsw2 c n2 1e9
R4s n2 0 4
L1 c b 1
R4r b 0 4
.end
