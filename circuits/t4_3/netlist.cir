* 教材 T4.3：A_u(jf) = 1000·jf/100 / [(1+jf/100)(1+jf/10^4)(1+jf/10^5)]
* 等效实现：CR 高通（fL=100 Hz）× 增益 1000 × 两级 RC 低通（10 kHz, 100 kHz）
* 各级用理想缓冲隔离，保证总传递函数严格等于题给表达式
Vin in 0 AC 1
* --- 下限频率：C1 + R1，fL = 1/(2*pi*R1*C1) = 100 Hz
C1 in b1 1u
R1 b1 0 1591.549431
E2 b1b 0 b1 0 1
* --- 中频增益 1000（60 dB）
E3 b2 0 b1b 0 1000
* --- 上限频率第一极点：f2 = 1/(2*pi*R2*C2) = 10 kHz
R2 b2 b3 1k
C2 b3 0 15.9154943n
E4 b3b 0 b3 0 1
* --- 上限频率第二极点：f3 = 1/(2*pi*R3*C3) = 100 kHz
R3 b3b out 1k
C3 out 0 1.59154943n
R4 out 0 1meg
.end
