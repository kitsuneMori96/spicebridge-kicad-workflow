* 教材第 18 题：带发射极电阻的共射放大器，求静态 U_CEQ
VCC vcc 0 12
V1 s 0 SIN(0 30m 1k) AC 1
R1 s in 1k
C1 in b 10u
R2 vcc b 510k
R3 vcc c 3k
Q1 c b e QNPN
R4 e 0 1k
C3 e 0 100u
C2 c out 10u
R5 out 0 3k
.model QNPN NPN(BF=100)
.end
